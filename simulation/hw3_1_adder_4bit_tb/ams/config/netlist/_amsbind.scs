// -----------------------------------------------------------------------------
// (c) Copyright 2010 Cadence Design Systems, Inc. All rights reserved worldwide.
// -----------------------------------------------------------------------------

// Binding AMSD Control Block for config ECE_6240_Digial.hw3_1_adder_4bit_tb:config
// Created On: Nov 18 17:28:14 2018
// NOTE      : DO NOT change this system generated file.

amsd {
	config designtop="ECE_6240_Digial.hw3_1_adder_4bit_tb:schematic"

	config cell="ami06N" view="analogtext"
	config cell="hw1_3_CMOS_3_Input_NOR" lib="ECE_6240_Digial" view="schematic"
	config cell="hw3_1_adder_4bit" lib="ECE_6240_Digial" view="schematic"
	config cell="ami06P" view="analogtext"
	config cell="vsource" view="analogtext"
	config cell="hw1_1_c_inverter" lib="ECE_6240_Digial" view="schematic"
	config cell="hw3_1_adder_1bit" lib="ECE_6240_Digial" view="schematic"
	config cell="hw1_3_CMOS_3_Input_NAND" lib="ECE_6240_Digial" view="schematic"
	config cell="hw1_3_CMOS_2_Input_NAND" lib="ECE_6240_Digial" view="schematic"
	config cell="hw1_3_CMOS_2_Input_NOR" lib="ECE_6240_Digial" view="schematic"
	config cell="hw3_1_adder_4bit_tb_vdriver" lib="ECE_6240_Digial" view="functional"

 }
