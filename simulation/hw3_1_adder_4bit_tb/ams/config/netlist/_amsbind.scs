// -----------------------------------------------------------------------------
// (c) Copyright 2010 Cadence Design Systems, Inc. All rights reserved worldwide.
// -----------------------------------------------------------------------------

// Binding AMSD Control Block for config ECE_6240_Digital.hw3_1_adder_4bit_tb:config
// Created On: Nov 27 14:33:44 2018
// NOTE      : DO NOT change this system generated file.

amsd {
	config designtop="ECE_6240_Digital.hw3_1_adder_4bit_tb:schematic"

	config cell="ami06N" view="analogtext"
	config cell="hw3_1_adder_4bit" lib="ECE_6240_Digital" view="schematic"
	config cell="hw1_3_CMOS_3_Input_NOR" lib="ECE_6240_Digital" view="schematic"
	config cell="ami06P" view="analogtext"
	config cell="hw3_1_4_Input_OR" lib="ECE_6240_Digital" view="schematic"
	config cell="vsource" view="analogtext"
	config cell="hw3_1_adder_1bit" lib="ECE_6240_Digital" view="schematic"
	config cell="hw1_1_c_inverter" lib="ECE_6240_Digital" view="schematic"
	config cell="hw3_1_3_Input_AND" lib="ECE_6240_Digital" view="schematic"
	config cell="hw3_1_2_Input_AND" lib="ECE_6240_Digital" view="schematic"
	config cell="hw1_3_CMOS_3_Input_NAND" lib="ECE_6240_Digital" view="schematic"
	config cell="hw3_1_4_Input_NOR" lib="ECE_6240_Digital" view="schematic"
	config cell="hw3_1_3_Input_OR" lib="ECE_6240_Digital" view="schematic"
	config cell="hw1_3_CMOS_2_Input_NAND" lib="ECE_6240_Digital" view="schematic"
	config cell="hw3_1_adder_4bit_tb_vdriver" lib="ECE_6240_Digital" view="functional"

 }
