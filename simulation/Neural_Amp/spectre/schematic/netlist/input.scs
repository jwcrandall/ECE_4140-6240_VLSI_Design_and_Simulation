// Design: 6218_Final_Project/Neural_Amp
simulator lang=spectre
global 0 vdd!
parameters p5vonly=0
include "/apps/design_kits/ncsu-cdk-1.6.0.beta/models/spectre/nom/ami06N.m"
include "/apps/design_kits/ncsu-cdk-1.6.0.beta/models/spectre/nom/ami06P.m"
include "/apps/design_kits/ncsu-cdk-1.6.0.beta/models/spectre/nom/ami16N.m"
include "/apps/design_kits/ncsu-cdk-1.6.0.beta/models/spectre/nom/ami16P.m"

// 6218_Final_Project/OTA/schematic
subckt OTA Vin Vout Vref inh_inh_bn
    M3 (net2 net2 0 gnd!) ami16N w=12.0u l=44.8u m=1 region=sat
    Mcasn (Vout net023 net12 gnd!) ami16N w=12.0u l=3.2u m=1 region=sat
    M6 (net12 net10 0 gnd!) ami16N w=12.0u l=44.8u m=1 region=sat
    M5 (net1 net2 0 gnd!) ami16N w=12.0u l=44.8u m=1 region=sat
    M4 (net10 net10 0 gnd!) ami16N w=12.0u l=44.8u m=1 region=sat
    M7 (net1 net1 vdd! vdd!) ami16P w=6.4u l=12.8u m=1 region=sat
    M1 (net2 Vin net9 vdd!) ami16P w=800.0000u l=4u m=1 region=subth
    M10 (net9 net14 vdd! vdd!) ami16P w=20u l=20u m=1 region=sat
    M9 (net14 net14 vdd! vdd!) ami16P w=20u l=20u m=1 region=sat
    Mcasp (Vout net021 net13 vdd!) ami16P w=6.4u l=3.2u m=1 region=sat
    M2 (net10 Vref net9 vdd!) ami16P w=800.0000u l=4u m=1 region=subth
    M8 (net13 net1 vdd! vdd!) ami16P w=6.4u l=12.8u m=1 region=sat
    V8 (vdd! 0) vsource type=dc dc=5
    V3 (net021 0) vsource type=dc dc=2.75
    V2 (net023 0) vsource type=dc dc=1.54
    I2 (net14 0) isource type=dc dc=8u m=1
ends OTA

// 6218_Final_Project/Neural_Amp/schematic
P3 (net015 net015 net9 net9) ami16P w=4.05u l=4.05u m=1 region=sat
P1 (net2 net2 net015 net015) ami16P w=4.05u l=4.05u m=1 region=sat
CL (net9 net017) capacitor c=4p m=1
C22 (net2 net9) capacitor c=8p m=1
C11 (net05 net2) capacitor c=900p m=1
V0 (net05 net01) vsource type=sine mag=10m
I4 (net2 net9 net01 0) OTA
V2 (net017 0) vsource type=dc dc=2.5
V1 (net01 0) vsource type=dc dc=2.5
simulatorOptions options temp=27 tnom=25
dcOp dc
