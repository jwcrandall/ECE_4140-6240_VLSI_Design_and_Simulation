// Design: Digial/inv_tb
simulator lang=spectre
global 0 vdd!
parameters p5vonly=0
include "/apps/design_kits/ncsu-cdk-1.6.0.beta/models/spectre/nom/ami06N.m"
include "/apps/design_kits/ncsu-cdk-1.6.0.beta/models/spectre/nom/ami06P.m"

// Digial/inv/schematic
subckt inv VIN VOUT
    P0 (VOUT VIN vdd! vdd!) ami06P w=1.95 l=600n m=1 region=sat
    N0 (VOUT VIN 0 0) ami06N w=1.5u l=600n m=1 region=sat
ends inv

// Digial/inv_tb/schematic
V1 (vin 0) vsource type=dc
V0 (vdd! 0) vsource type=dc dc=5
C0 (vout 0) capacitor c=10p m=1
I5 (vin vout) inv
simulatorOptions options temp=27 tnom=25
tran tran stop=150u
