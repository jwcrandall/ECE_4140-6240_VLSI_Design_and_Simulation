simulator( 'spectre )
design(	 "/home/seas/jwcrandall/cadence/simulation/hw1_1_inverter_tb/spectre/schematic/netlist/netlist")
resultsDir( "/home/seas/jwcrandall/cadence/simulation/hw1_1_inverter_tb/spectre/schematic" )
modelFile(
    '("/apps/design_kits/ncsu-cdk-1.6.0.beta/models/spectre/nom/ami06N.m" "")
    '("/apps/design_kits/ncsu-cdk-1.6.0.beta/models/spectre/nom/ami06P.m" "")
)
analysis('dc ?saveOppoint t  )
desVar(	  "p5vonly" 0	)
envOption(
	'analysisOrder  list("dc")
)
temp( 27 )
run()
selectResult( 'dcOp )
plot(getData("/vout") getData("/vin") )
modelFile(
    '("/apps/design_kits/ncsu-cdk-1.6.0.beta/models/spectre/nom/ami06N.m" "")
    '("/apps/design_kits/ncsu-cdk-1.6.0.beta/models/spectre/nom/ami06P.m" "")
)
run()
selectResult( 'dcOp )
plot(getData("/vout") getData("/vin") )
modelFile(
    '("/apps/design_kits/ncsu-cdk-1.6.0.beta/models/spectre/nom/ami06N.m" "")
    '("/apps/design_kits/ncsu-cdk-1.6.0.beta/models/spectre/nom/ami06P.m" "")
)
analysis('tran ?stop "150u"  )
envOption(
	'analysisOrder  list("dc" "tran")
)
run()
selectResult( 'tran )
plot(getData("/vout") getData("/vin") )
modelFile(
    '("/apps/design_kits/ncsu-cdk-1.6.0.beta/models/spectre/nom/ami06N.m" "")
    '("/apps/design_kits/ncsu-cdk-1.6.0.beta/models/spectre/nom/ami06P.m" "")
)
analysis('dc ?saveOppoint t  ?dev "/V1"  ?param "dc"
		?start "0"  ?stop "5"  )
run()
selectResult( 'dc )
plot(getData("/vout") )
modelFile(
    '("/apps/design_kits/ncsu-cdk-1.6.0.beta/models/spectre/nom/ami06N.m" "")
    '("/apps/design_kits/ncsu-cdk-1.6.0.beta/models/spectre/nom/ami06P.m" "")
)
analysis('tran ?stop "150u"  )
run()
selectResult( 'tran )
plot(getData("/vin") getData("/vout") )
modelFile(
    '("/apps/design_kits/ncsu-cdk-1.6.0.beta/models/spectre/nom/ami06N.m" "")
    '("/apps/design_kits/ncsu-cdk-1.6.0.beta/models/spectre/nom/ami06P.m" "")
)
run()
selectResult( 'tran )
plot(getData("/vin") getData("/vout") )
modelFile(
    '("/apps/design_kits/ncsu-cdk-1.6.0.beta/models/spectre/nom/ami06N.m" "")
    '("/apps/design_kits/ncsu-cdk-1.6.0.beta/models/spectre/nom/ami06P.m" "")
)
run()
selectResult( 'tran )
plot(getData("/vin") getData("/vout") )
