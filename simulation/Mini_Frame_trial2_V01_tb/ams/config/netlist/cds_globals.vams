// Verilog-AMS cds_globals module for top-level cell:
//    project_g01/Mini_Frame_trial2_V01_tb.
// Generated by ADE.
// Cadence Design Systems, Inc.

// This is an autoGenerated file, any changes done to this file may get lost.

`include "disciplines.vams"
`include "userDisciplines.vams"

module cds_globals;

// Global Signals
   wire \vdd! ;
   electrical \gnd! ;
   ground \gnd! ;

// Design Variables
   dynamicparam real p5vonly = 0;

endmodule
