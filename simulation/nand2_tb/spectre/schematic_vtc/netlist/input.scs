// Design: Digial/nand2_tb
simulator lang=spectre
global 0 vdd!
parameters w_n=1.5 w_p=1.5
include "/apps/design_kits/ncsu-cdk-1.6.0.beta/models/spectre/nom/ami06N.m"
include "/apps/design_kits/ncsu-cdk-1.6.0.beta/models/spectre/nom/ami06P.m"

// Digial/nand2/schematic
subckt nand2 A B OUT
    P1 (OUT B vdd! vdd!) ami06P w=1.5u l=600n m=1 region=sat
    P0 (OUT A vdd! vdd!) ami06P w=1.5u l=600n m=1 region=sat
    N2 (net07 B 0 0) ami06N w=2.4u l=600n m=1 region=sat
    N0 (OUT A net07 0) ami06N w=2.4u l=600n m=1 region=sat
ends nand2

// Digial/nand2_tb/schematic_vtc
V1 (IN 0) vsource type=dc dc=0
V0 (vdd! 0) vsource type=dc dc=5
I5 (IN IN OUT) nand2
C0 (OUT 0) capacitor c=10p m=1
simulatorOptions options temp=27 tnom=25
dc dc dev=V1 param=dc start=0 stop=5
save I5:2 I5:1 I5:3
