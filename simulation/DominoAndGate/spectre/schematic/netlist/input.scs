// Design: Digial/DominoAndGate
simulator lang=spectre
global 0 vdd!
parameters p5vonly=0
include "/apps/design_kits/ncsu-cdk-1.6.0.beta/models/spectre/nom/ami06N.m"
include "/apps/design_kits/ncsu-cdk-1.6.0.beta/models/spectre/nom/ami06P.m"

// Digial/inv_min/schematic
subckt inv_min VIN VOUT
    P0 (VOUT VIN vdd! vdd!) ami06P w=1.5 l=600n m=1 region=sat
    N0 (VOUT VIN 0 0) ami06N w=1.5u l=600n m=1 region=sat
ends inv_min

// Digial/DominoAndGate/schematic
V0 (vdd! 0) vsource type=dc dc=3.3
N3 (net015 phi 0 0) ami06N w=1.5u l=600n m=1 region=sat
N2 (W B net014 0) ami06N w=1.5u l=600n m=1 region=sat
N1 (net014 A net015 0) ami06N w=1.5u l=600n m=1 region=sat
Vphi (phi 0) vsource type=pulse val0=0 val1=3.3 period=40n rise=50p width=20n
VB (B 0) vsource type=pulse val0=0 val1=3.3 period=320n width=160n
VA (A 0) vsource type=pulse val0=0 val1=3.3 period=160n width=80n
P0 (W phi vdd! vdd!) ami06P w=1.5u l=600n m=1 region=sat
CX (X 0) capacitor c=1p m=1
I11 (W X) inv_min
simulatorOptions options temp=27 tnom=25
tran tran stop=1u
