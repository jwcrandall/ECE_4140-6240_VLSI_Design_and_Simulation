// AMS netlist generated by the AMS Unified netlister
// IC subversion:  IC6.1.7-64b.500.22
// IUS version: 15.20-s045
// Copyright(C) 2005-2009, Cadence Design Systems, Inc
// User: jwcrandall Pid: 12529
// Design library name: ECE_6240_Digital
// Design cell name: hw3_1_mirror_adder_4bit_tb
// Design view name: config
// Solver: Spectre

`include "disciplines.vams"
`include "userDisciplines.vams"
// HDL file - ECE_6240_Digital, hw3_1_mirror_adder_4bit_tb_vdriver, functional.
// Library - ECE_6240_Digital, Cell - hw1_1_c_inverter, View - schematic
// LAST TIME SAVED: Oct 16 17:53:52 2018
// NETLIST TIME: Nov 29 10:59:51 2018

`worklib ECE_6240_Digital
`view schematic

`timescale 1ns / 1ns
(* cds_ams_schematic *)

module hw1_1_c_inverter (VOUT, VIN);
output  VOUT;
input  VIN;
ami06P #(.w(3e-06), .l(6e-07), .as(4.5e-12), .ad(4.5e-12), .ps(9e-06), .pd(9e-06), .m(1), .region("sat"))
(* integer passed_mfactor = "m"; *)
 P0 (VOUT, VIN, cds_globals.\vdd! , cds_globals.\vdd! );
ami06N #(.w(1.5e-06), .l(6e-07), .as(2.25e-12), .ad(2.25e-12), .ps(6e-06), .pd(6e-06), .m(1), .region("sat"))
(* integer passed_mfactor = "m"; *)
 N0 (VOUT, VIN, cds_globals.\gnd! , cds_globals.\gnd! );

endmodule
// Library - ECE_6240_Digital, Cell - hw3_1_mirror_adder_1bit, View - schematic
// LAST TIME SAVED: Nov 29 10:00:54 2018
// NETLIST TIME: Nov 29 10:59:51 2018

`worklib ECE_6240_Digital
`view schematic

`timescale 1ns / 1ns
(* cds_ams_schematic *)

module hw3_1_mirror_adder_1bit (Cout, S, A, B, Cin);
output  Cout, S;
input  A, B, Cin;
wire net32;
wire net10;
hw1_1_c_inverter I3 (.VOUT( S ), .VIN( net32 ));
hw1_1_c_inverter I2 (.VOUT( Cout ), .VIN( net10 ));
ami06P #(.w(1.5e-06), .l(6e-07), .as(2.25e-12), .ad(2.25e-12), .ps(6e-06), .pd(6e-06), .m(1), .region("sat"))
(* integer passed_mfactor = "m"; *)
 P11 (net32, net10, net35, cds_globals.\vdd! );
ami06P #(.w(1.5e-06), .l(6e-07), .as(2.25e-12), .ad(2.25e-12), .ps(6e-06), .pd(6e-06), .m(1), .region("sat"))
(* integer passed_mfactor = "m"; *)
 P10 (net10, A, net24, cds_globals.\vdd! );
ami06P #(.w(1.5e-06), .l(6e-07), .as(2.25e-12), .ad(2.25e-12), .ps(6e-06), .pd(6e-06), .m(1), .region("sat"))
(* integer passed_mfactor = "m"; *)
 P9 (net10, Cin, net11, cds_globals.\vdd! );
ami06P #(.w(1.5e-06), .l(6e-07), .as(2.25e-12), .ad(2.25e-12), .ps(6e-06), .pd(6e-06), .m(1), .region("sat"))
(* integer passed_mfactor = "m"; *)
 P8 (net25, B, cds_globals.\vdd! , cds_globals.\vdd! );
ami06P #(.w(1.5e-06), .l(6e-07), .as(2.25e-12), .ad(2.25e-12), .ps(6e-06), .pd(6e-06), .m(1), .region("sat"))
(* integer passed_mfactor = "m"; *)
 P7 (net26, A, net25, cds_globals.\vdd! );
ami06P #(.w(1.5e-06), .l(6e-07), .as(2.25e-12), .ad(2.25e-12), .ps(6e-06), .pd(6e-06), .m(1), .region("sat"))
(* integer passed_mfactor = "m"; *)
 P6 (net32, Cin, net26, cds_globals.\vdd! );
ami06P #(.w(1.5e-06), .l(6e-07), .as(2.25e-12), .ad(2.25e-12), .ps(6e-06), .pd(6e-06), .m(1), .region("sat"))
(* integer passed_mfactor = "m"; *)
 P5 (net35, Cin, cds_globals.\vdd! , cds_globals.\vdd! );
ami06P #(.w(1.5e-06), .l(6e-07), .as(2.25e-12), .ad(2.25e-12), .ps(6e-06), .pd(6e-06), .m(1), .region("sat"))
(* integer passed_mfactor = "m"; *)
 P4 (net35, B, cds_globals.\vdd! , cds_globals.\vdd! );
ami06P #(.w(1.5e-06), .l(6e-07), .as(2.25e-12), .ad(2.25e-12), .ps(6e-06), .pd(6e-06), .m(1), .region("sat"))
(* integer passed_mfactor = "m"; *)
 P3 (net35, A, cds_globals.\vdd! , cds_globals.\vdd! );
ami06P #(.w(1.5e-06), .l(6e-07), .as(2.25e-12), .ad(2.25e-12), .ps(6e-06), .pd(6e-06), .m(1), .region("sat"))
(* integer passed_mfactor = "m"; *)
 P2 (net24, B, cds_globals.\vdd! , cds_globals.\vdd! );
ami06P #(.w(1.5e-06), .l(6e-07), .as(2.25e-12), .ad(2.25e-12), .ps(6e-06), .pd(6e-06), .m(1), .region("sat"))
(* integer passed_mfactor = "m"; *)
 P1 (net11, B, cds_globals.\vdd! , cds_globals.\vdd! );
ami06P #(.w(1.5e-06), .l(6e-07), .as(2.25e-12), .ad(2.25e-12), .ps(6e-06), .pd(6e-06), .m(1), .region("sat"))
(* integer passed_mfactor = "m"; *)
 P0 (net11, A, cds_globals.\vdd! , cds_globals.\vdd! );
ami06N #(.w(1.5e-06), .l(6e-07), .as(2.25e-12), .ad(2.25e-12), .ps(6e-06), .pd(6e-06), .m(1), .region("sat"))
(* integer passed_mfactor = "m"; *)
 N11 (net32, net10, net059, cds_globals.\gnd! );
ami06N #(.w(1.5e-06), .l(6e-07), .as(2.25e-12), .ad(2.25e-12), .ps(6e-06), .pd(6e-06), .m(1), .region("sat"))
(* integer passed_mfactor = "m"; *)
 N10 (net022, B, cds_globals.\gnd! , cds_globals.\gnd! );
ami06N #(.w(1.5e-06), .l(6e-07), .as(2.25e-12), .ad(2.25e-12), .ps(6e-06), .pd(6e-06), .m(1), .region("sat"))
(* integer passed_mfactor = "m"; *)
 N9 (net021, A, net022, cds_globals.\gnd! );
ami06N #(.w(1.5e-06), .l(6e-07), .as(2.25e-12), .ad(2.25e-12), .ps(6e-06), .pd(6e-06), .m(1), .region("sat"))
(* integer passed_mfactor = "m"; *)
 N8 (net32, Cin, net021, cds_globals.\gnd! );
ami06N #(.w(1.5e-06), .l(6e-07), .as(2.25e-12), .ad(2.25e-12), .ps(6e-06), .pd(6e-06), .m(1), .region("sat"))
(* integer passed_mfactor = "m"; *)
 N7 (net059, Cin, cds_globals.\gnd! , cds_globals.\gnd! );
ami06N #(.w(1.5e-06), .l(6e-07), .as(2.25e-12), .ad(2.25e-12), .ps(6e-06), .pd(6e-06), .m(1), .region("sat"))
(* integer passed_mfactor = "m"; *)
 N6 (net059, B, cds_globals.\gnd! , cds_globals.\gnd! );
ami06N #(.w(1.5e-06), .l(6e-07), .as(2.25e-12), .ad(2.25e-12), .ps(6e-06), .pd(6e-06), .m(1), .region("sat"))
(* integer passed_mfactor = "m"; *)
 N5 (net059, A, cds_globals.\gnd! , cds_globals.\gnd! );
ami06N #(.w(1.5e-06), .l(6e-07), .as(2.25e-12), .ad(2.25e-12), .ps(6e-06), .pd(6e-06), .m(1), .region("sat"))
(* integer passed_mfactor = "m"; *)
 N4 (net10, A, net23, cds_globals.\gnd! );
ami06N #(.w(1.5e-06), .l(6e-07), .as(2.25e-12), .ad(2.25e-12), .ps(6e-06), .pd(6e-06), .m(1), .region("sat"))
(* integer passed_mfactor = "m"; *)
 N3 (net23, B, cds_globals.\gnd! , cds_globals.\gnd! );
ami06N #(.w(1.5e-06), .l(6e-07), .as(2.25e-12), .ad(2.25e-12), .ps(6e-06), .pd(6e-06), .m(1), .region("sat"))
(* integer passed_mfactor = "m"; *)
 N2 (net9, B, cds_globals.\gnd! , cds_globals.\gnd! );
ami06N #(.w(1.5e-06), .l(6e-07), .as(2.25e-12), .ad(2.25e-12), .ps(6e-06), .pd(6e-06), .m(1), .region("sat"))
(* integer passed_mfactor = "m"; *)
 N1 (net9, A, cds_globals.\gnd! , cds_globals.\gnd! );
ami06N #(.w(1.5e-06), .l(6e-07), .as(2.25e-12), .ad(2.25e-12), .ps(6e-06), .pd(6e-06), .m(1), .region("sat"))
(* integer passed_mfactor = "m"; *)
 N0 (net10, Cin, net9, cds_globals.\gnd! );

endmodule
// Library - ECE_6240_Digital, Cell - hw3_1_mirror_adder_4bit, View - schematic
// LAST TIME SAVED: Nov 29 10:30:45 2018
// NETLIST TIME: Nov 29 10:59:51 2018

`worklib ECE_6240_Digital
`view schematic

`timescale 1ns / 1ns
(* cds_ams_schematic *)

module hw3_1_mirror_adder_4bit (Cout, .S0(S), S1, S2, S3, A0, A1, A2, A3, B0, B1, B2, B3, Cin);
output  Cout, S, S1, S2, S3;
input  A0, A1, A2, A3, B0, B1, B2, B3, Cin;
wire net30;
wire net29;
wire net28;
hw3_1_mirror_adder_1bit I3 (.Cout( net30 ), .S( S ), .A( A0 ), .B( B0 ), .Cin( Cin ));
hw3_1_mirror_adder_1bit I2 (.Cout( net29 ), .S( S1 ), .A( A1 ), .B( B1 ), .Cin( net30 ));
hw3_1_mirror_adder_1bit I1 (.Cout( Cout ), .S( S3 ), .A( A3 ), .B( B3 ), .Cin( net28 ));
hw3_1_mirror_adder_1bit I0 (.Cout( net28 ), .S( S2 ), .A( A2 ), .B( B2 ), .Cin( net29 ));

endmodule
// Library - ECE_6240_Digital, Cell - hw3_1_mirror_adder_4bit_tb, View - schematic
// LAST TIME SAVED: Nov 29 10:58:00 2018
// NETLIST TIME: Nov 29 10:59:51 2018

`worklib ECE_6240_Digital
`view schematic

`timescale 1ns / 1ns
(* cds_ams_schematic *)

module hw3_1_mirror_adder_4bit_tb ( );
wire [3:0] A_data;
wire [3:0] B_data;
wire [3:0] sum;
wire Cout;
wire Cin;
hw3_1_mirror_adder_4bit_tb_vdriver I37 (.A_data( A_data ), .B_data( B_data ), .c_in( Cin ), .c_out( Cout ), .sum( sum ));
hw3_1_mirror_adder_4bit I36 (.Cout( Cout ), .S0( sum[0] ), .S1( sum[1] ), .S2( sum[2] ), .S3( sum[3] ), .A0( A_data[0] ), .A1( A_data[1] ), .A2( A_data[2] ), .A3( A_data[3] ), .B0( B_data[0] ), .B1( B_data[1] ), .B2( B_data[2] ), .B3( B_data[3] ), .Cin( Cin ));
vsource #(.type("dc"), .dc(5)) V0 (cds_globals.\vdd! , cds_globals.\gnd! );

endmodule
`noworklib
`noview
