// Generated for: spectre
// Generated on: Nov 17 13:01:36 2018
// Design library name: project_g01
// Design cell name: nand2
// Design view name: extracted
simulator lang=spectre
global 0
parameters p5vonly=0
include "/apps/design_kits/ncsu-cdk-1.6.0.beta/models/spectre/nom/ami06N.m"
include "/apps/design_kits/ncsu-cdk-1.6.0.beta/models/spectre/nom/ami06P.m"

// Library name: project_g01
// Cell name: nand2
// View name: extracted
\+3 (OUT B vdd! vdd!) ami06P w=1.5e-06 l=6e-07 as=1.35e-12 ad=2.25e-12 \
        ps=1.8e-06 pd=4.5e-06 m=1 region=sat
\+2 (vdd! A OUT vdd!) ami06P w=1.5e-06 l=6e-07 as=2.25e-12 ad=1.35e-12 \
        ps=4.5e-06 pd=1.8e-06 m=1 region=sat
\+11 (B gnd!) capacitor c=1.02951e-15 m=1
\+10 (A gnd!) capacitor c=1.02951e-15 m=1
\+9 (vdd! B) capacitor c=1.3392e-16 m=1
\+8 (vdd! A) capacitor c=1.3392e-16 m=1
\+7 (OUT gnd!) capacitor c=5.83092e-15 m=1
\+6 (B OUT) capacitor c=2.7e-16 m=1
\+5 (A OUT) capacitor c=2.7e-16 m=1
\+4 (vdd! OUT) capacitor c=8.9472e-16 m=1
\+1 (gnd! B 6 gnd!) ami06N w=2.1e-06 l=6e-07 as=1.89e-12 ad=3.15e-12 \
        ps=1.8e-06 pd=5.1e-06 m=1 region=sat
\+0 (6 A OUT gnd!) ami06N w=2.1e-06 l=6e-07 as=3.15e-12 ad=1.89e-12 \
        ps=5.1e-06 pd=1.8e-06 m=1 region=sat
include "/home/seas/jwcrandall/cadence/simulation/nand2/spectre/extracted/netlist/stimuli/stimulus_nand2.txt"
simulatorOptions options reltol=1e-3 vabstol=1e-6 iabstol=1e-12 temp=27 \
    tnom=25 scalem=1.0 scale=1.0 gmin=1e-12 rforce=1 maxnotes=5 maxwarns=5 \
    digits=5 cols=80 pivrel=1e-3 sensfile="../psf/sens.output" \
    checklimitdest=psf
tran tran stop=150u write="spectre.ic" writefinal="spectre.fc" \
    annotate=status maxiters=5
finalTimeOP info what=oppoint where=rawfile
modelParameter info what=models where=rawfile
element info what=inst where=rawfile
outputParameter info what=output where=rawfile
designParamVals info what=parameters where=rawfile
primitives info what=primitives where=rawfile
subckts info what=subckts where=rawfile
saveOptions options save=allpub
