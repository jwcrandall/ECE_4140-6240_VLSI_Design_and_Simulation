// AMS netlist generated by the AMS Unified netlister
// IC subversion:  IC6.1.7-64b.500.17
// IUS version: 15.20-s045
// Copyright(C) 2005-2009, Cadence Design Systems, Inc
// User: jwcrandall Pid: 6725
// Design library name: ECE_6240_Digial
// Design cell name: lab9_b_inv_tb2
// Design view name: config
// Solver: Spectre

`include "disciplines.vams"
`include "userDisciplines.vams"
// HDL file - ECE_6240_Digial, lab9_b_inv_tb_vdriver, functional.
// Library - ECE_6240_Digial, Cell - inv, View - schematic
// LAST TIME SAVED: Sep 18 16:49:00 2018
// NETLIST TIME: Oct 30 16:51:51 2018

`worklib ECE_6240_Digial
`view schematic

`timescale 1ns / 1ns
(* cds_ams_schematic *)

module inv (VOUT, VIN);
output  VOUT;
input  VIN;
ami06P #(.w(1.95), .l(6e-07), .as(2.925e-06), .ad(2.925e-06), .ps(3.9), .pd(3.9), .m(1), .region("sat"))
(* integer passed_mfactor = "m"; *)
 P0 (VOUT, VIN, cds_globals.\vdd! , cds_globals.\vdd! );
ami06N #(.w(1.5e-06), .l(6e-07), .as(2.25e-12), .ad(2.25e-12), .ps(6e-06), .pd(6e-06), .m(1), .region("sat"))
(* integer passed_mfactor = "m"; *)
 N0 (VOUT, VIN, cds_globals.\gnd! , cds_globals.\gnd! );

endmodule
// Library - ECE_6240_Digial, Cell - lab9_b_inv_tb2, View - schematic
// LAST TIME SAVED: Oct 30 15:41:57 2018
// NETLIST TIME: Oct 30 16:51:51 2018

`worklib ECE_6240_Digial
`view schematic

`timescale 1ns / 1ns
(* cds_ams_schematic *)

module lab9_b_inv_tb2 ( );
wire VIN;
wire VOUT;
lab9_b_inv_tb_vdriver I2 (.test_data( VIN ));
inv I3 (.VOUT( VOUT ), .VIN( VIN ));
vsource #(.type("dc"), .dc(5)) V0 (cds_globals.\vdd! , cds_globals.\gnd! );
capacitor #(.c(1e-12), .m(1))
(* integer passed_mfactor = "m"; *)
 C0 (VOUT, cds_globals.\gnd! );

endmodule
`noworklib
`noview
