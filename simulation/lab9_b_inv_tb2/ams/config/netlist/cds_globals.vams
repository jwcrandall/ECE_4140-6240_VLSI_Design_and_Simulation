// Verilog-AMS cds_globals module for top-level cell:
//    ECE_6240_Digial/lab9_b_inv_tb2.
// Generated by ADE.
// Cadence Design Systems, Inc.

// This is an autoGenerated file, any changes done to this file may get lost.

`include "disciplines.vams"
`include "userDisciplines.vams"

module cds_globals;

// Global Signals
   electrical \gnd! ;
   ground \gnd! ;
   wire \vdd! ;

// Design Variables
   dynamicparam real p5vonly = 0;

endmodule
