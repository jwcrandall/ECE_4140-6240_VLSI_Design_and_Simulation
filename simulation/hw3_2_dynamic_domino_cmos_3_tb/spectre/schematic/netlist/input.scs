// Design: ECE_6240_Digital/hw3_2_dynamic_domino_cmos_3_tb
simulator lang=spectre
global 0 gnda! vdd!
parameters p5vonly=0
include "/apps/design_kits/ncsu-cdk-1.6.0.beta/models/spectre/nom/ami06N.m"
include "/apps/design_kits/ncsu-cdk-1.6.0.beta/models/spectre/nom/ami06P.m"

// ECE_6240_Digital/hw1_1_c_inverter/schematic
subckt hw1_1_c_inverter VIN VOUT
    P0 (VOUT VIN vdd! vdd!) ami06P w=3u l=600n m=1 region=sat
    N0 (VOUT VIN 0 0) ami06N w=1.5u l=600n m=1 region=sat
ends hw1_1_c_inverter

// ECE_6240_Digital/hw3_2_dynamic_domino_cmos_3/schematic
subckt hw3_2_dynamic_domino_cmos_3 A B C Clk F
    N3 (net9 Clk gnda! gnda!) ami06N w=1.5u l=600n m=1 region=sat
    N2 (net09 C net9 net9) ami06N w=1.5u l=600n m=1 region=sat
    N1 (net09 B net9 net9) ami06N w=1.5u l=600n m=1 region=sat
    N0 (net09 A net9 net9) ami06N w=1.5u l=600n m=1 region=sat
    P0 (net09 Clk vdd! vdd!) ami06P w=1.5u l=600n m=1 region=sat
    I2 (net09 F) hw1_1_c_inverter
ends hw3_2_dynamic_domino_cmos_3

// ECE_6240_Digital/hw3_2_dynamic_domino_cmos_3_tb/schematic
V0 (vdd! 0) vsource type=dc dc=5
V4 (Clk 0) vsource type=pulse dc=5 val0=0 val1=5 period=320u delay=0 rise=500f fall=500f width=160u
V3 (C 0) vsource type=pulse dc=5 val0=0 val1=5 period=160u delay=0 rise=500f fall=500f width=80u
V2 (B 0) vsource type=pulse dc=5 val0=0 val1=5 period=80u delay=0 rise=500f fall=500f width=40u
V1 (A 0) vsource type=pulse dc=5 val0=0 val1=5 period=40u delay=0 rise=500f fall=500f width=20u
C0 (F 0) capacitor c=4p m=1
I13 (A B C Clk F) hw3_2_dynamic_domino_cmos_3
simulatorOptions options temp=27 tnom=25
tran tran stop=400u
