// Design: ECE_6240_Digial/hw1_1_c_inverter_tb
simulator lang=spectre
global 0 vdd!
parameters p5vonly=0
include "/apps/design_kits/ncsu-cdk-1.6.0.beta/models/spectre/nom/ami06N.m"
include "/apps/design_kits/ncsu-cdk-1.6.0.beta/models/spectre/nom/ami06P.m"

// ECE_6240_Digial/hw1_1_c_inverter/schematic
subckt hw1_1_c_inverter VIN VOUT
    P0 (VOUT VIN vdd! vdd!) ami06P w=3u l=600n m=1 region=sat
    N0 (VOUT VIN 0 0) ami06N w=1.5u l=600n m=1 region=sat
ends hw1_1_c_inverter

// ECE_6240_Digial/hw1_1_c_inverter_tb/schematic
V0 (vdd! 0) vsource type=dc dc=5
V1 (vin 0) vsource type=pulse val0=0 val1=5 period=50u delay=0 rise=500f fall=500f width=25u
C0 (vout 0) capacitor c=4p m=1
I7 (vin vout) hw1_1_c_inverter
simulatorOptions options temp=27 tnom=25
tran tran stop=150u
