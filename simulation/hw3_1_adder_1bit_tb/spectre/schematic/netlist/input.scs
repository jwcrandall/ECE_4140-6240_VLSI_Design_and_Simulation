// Design: ECE_6240_Digital/hw3_1_adder_1bit_tb
simulator lang=spectre
global 0 vdd!
parameters p5vonly=0
include "/apps/design_kits/ncsu-cdk-1.6.0.beta/models/spectre/nom/ami06N.m"
include "/apps/design_kits/ncsu-cdk-1.6.0.beta/models/spectre/nom/ami06P.m"

// ECE_6240_Digital/hw3_1_4_Input_NOR/schematic
subckt hw3_1_4_Input_NOR A B C D Out
    N3 (Out D 0 0) ami06N w=1.5u l=600n m=1 region=sat
    N2 (Out C 0 0) ami06N w=1.5u l=600n m=1 region=sat
    N1 (Out B 0 0) ami06N w=1.5u l=600n m=1 region=sat
    N0 (Out A 0 0) ami06N w=1.5u l=600n m=1 region=sat
    P0 (net018 A vdd! vdd!) ami06P w=1.5u l=600n m=1 region=sat
    P1 (net18 B net018 vdd!) ami06P w=1.5u l=600n m=1 region=sat
    P2 (net19 C net18 vdd!) ami06P w=1.5u l=600n m=1 region=sat
    P3 (Out D net19 vdd!) ami06P w=1.5u l=600n m=1 region=sat
ends hw3_1_4_Input_NOR

// ECE_6240_Digital/hw1_1_c_inverter/schematic
subckt hw1_1_c_inverter VIN VOUT
    P0 (VOUT VIN vdd! vdd!) ami06P w=3u l=600n m=1 region=sat
    N0 (VOUT VIN 0 0) ami06N w=1.5u l=600n m=1 region=sat
ends hw1_1_c_inverter

// ECE_6240_Digital/hw3_1_4_Input_OR/schematic
subckt hw3_1_4_Input_OR A B C D Out
    I0 (A B C D net11) hw3_1_4_Input_NOR
    I1 (net11 Out) hw1_1_c_inverter
ends hw3_1_4_Input_OR

// ECE_6240_Digital/hw1_3_CMOS_2_Input_NAND/schematic
subckt hw1_3_CMOS_2_Input_NAND A B Out
    P0 (Out A vdd! vdd!) ami06P w=1.5u l=600n m=1 region=sat
    P1 (Out B vdd! vdd!) ami06P w=1.5u l=600n m=1 region=sat
    N1 (net14 B 0 0) ami06N w=1.5u l=600n m=1 region=sat
    N0 (Out A net14 0) ami06N w=1.5u l=600n m=1 region=sat
ends hw1_3_CMOS_2_Input_NAND

// ECE_6240_Digital/hw3_1_2_Input_AND/schematic
subckt hw3_1_2_Input_AND A B Out
    I0 (A B net7) hw1_3_CMOS_2_Input_NAND
    I1 (net7 Out) hw1_1_c_inverter
ends hw3_1_2_Input_AND

// ECE_6240_Digital/hw1_3_CMOS_3_Input_NOR/schematic
subckt hw1_3_CMOS_3_Input_NOR A B C Out
    N2 (Out C 0 0) ami06N w=1.5u l=600n m=1 region=sat
    N1 (Out B 0 0) ami06N w=1.5u l=600n m=1 region=sat
    N0 (Out A 0 0) ami06N w=1.5u l=600n m=1 region=sat
    P0 (net18 A vdd! vdd!) ami06P w=1.5u l=600n m=1 region=sat
    P1 (net19 B net18 vdd!) ami06P w=1.5u l=600n m=1 region=sat
    P2 (Out C net19 vdd!) ami06P w=1.5u l=600n m=1 region=sat
ends hw1_3_CMOS_3_Input_NOR

// ECE_6240_Digital/hw3_1_3_Input_OR/schematic
subckt hw3_1_3_Input_OR A B C Out
    I0 (A B C net9) hw1_3_CMOS_3_Input_NOR
    I1 (net9 Out) hw1_1_c_inverter
ends hw3_1_3_Input_OR

// ECE_6240_Digital/hw1_3_CMOS_3_Input_NAND/schematic
subckt hw1_3_CMOS_3_Input_NAND A B C Out
    P0 (Out A vdd! vdd!) ami06P w=1.5u l=600n m=1 region=sat
    P1 (Out B vdd! vdd!) ami06P w=1.5u l=600n m=1 region=sat
    P2 (Out C vdd! vdd!) ami06P w=1.5u l=600n m=1 region=sat
    N2 (net20 C 0 0) ami06N w=1.5u l=600n m=1 region=sat
    N1 (net19 B net20 0) ami06N w=1.5u l=600n m=1 region=sat
    N0 (Out A net19 0) ami06N w=1.5u l=600n m=1 region=sat
ends hw1_3_CMOS_3_Input_NAND

// ECE_6240_Digital/hw3_1_3_Input_AND/schematic
subckt hw3_1_3_Input_AND A B C Out
    I0 (A B C net9) hw1_3_CMOS_3_Input_NAND
    I1 (net9 Out) hw1_1_c_inverter
ends hw3_1_3_Input_AND

// ECE_6240_Digital/hw3_1_adder_1bit/schematic
subckt hw3_1_adder_1bit A B Cin Cout Sum
    I43 (net20 net19 net18 net17 Sum) hw3_1_4_Input_OR
    I38 (B Cin net15) hw3_1_2_Input_AND
    I37 (A Cin net34) hw3_1_2_Input_AND
    I36 (A B net16) hw3_1_2_Input_AND
    I42 (net16 net34 net15 Cout) hw3_1_3_Input_OR
    I2 (Cin net14) hw1_1_c_inverter
    I1 (B net11) hw1_1_c_inverter
    I0 (A net8) hw1_1_c_inverter
    I32 (net8 B net14 net20) hw3_1_3_Input_AND
    I33 (A net11 net14 net19) hw3_1_3_Input_AND
    I34 (net8 net11 Cin net18) hw3_1_3_Input_AND
    I35 (A B Cin net17) hw3_1_3_Input_AND
ends hw3_1_adder_1bit

// ECE_6240_Digital/hw3_1_adder_1bit_tb/schematic
V0 (vdd! 0) vsource type=dc dc=5
V3 (Cin 0) vsource type=pulse dc=5 val0=0 val1=5 period=200u delay=0 rise=500f fall=500f width=100u
V2 (A 0) vsource type=pulse dc=5 val0=0 val1=5 period=50u delay=0 rise=500f fall=500f width=25u
V1 (B 0) vsource type=pulse dc=5 val0=0 val1=5 period=100u delay=0 rise=500f fall=500f width=50u
C1 (Sum 0) capacitor c=4p m=1
C0 (Cout 0) capacitor c=4p m=1
I15 (A B Cin Cout Sum) hw3_1_adder_1bit
simulatorOptions options temp=27 tnom=25
tran tran stop=250u
