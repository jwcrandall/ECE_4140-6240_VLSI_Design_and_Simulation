simulator( 'spectre )
design(	 "/home/seas/jwcrandall/cadence/simulation/hw1_1_inverter/spectre/schematic/netlist/netlist")
resultsDir( "/home/seas/jwcrandall/cadence/simulation/hw1_1_inverter/spectre/schematic" )
modelFile(
    '("/apps/design_kits/ncsu-cdk-1.6.0.beta/models/spectre/nom/ami06N.m" "")
    '("/apps/design_kits/ncsu-cdk-1.6.0.beta/models/spectre/nom/ami06P.m" "")
)
desVar(	  "p5vonly" 0	)
temp( 27 )
run()
modelFile(
    '("/apps/design_kits/ncsu-cdk-1.6.0.beta/models/spectre/nom/ami06N.m" "")
    '("/apps/design_kits/ncsu-cdk-1.6.0.beta/models/spectre/nom/ami06P.m" "")
)
analysis('dc ?saveOppoint t  )
envOption(
	'analysisOrder  list("dc")
)
run()
selectResult( 'dcOp )
plot(getData("/VOUT") getData("/VIN") )
modelFile(
    '("/apps/design_kits/ncsu-cdk-1.6.0.beta/models/spectre/nom/ami06N.m" "")
    '("/apps/design_kits/ncsu-cdk-1.6.0.beta/models/spectre/nom/ami06P.m" "")
)
run()
selectResult( 'dcOp )
plot(getData("/VIN") getData("/VOUT") )
